* Module relais actif haut commande par GPIO -> Rs
.param BF_BC337=182.9 VTO_4905=-3 VCC=5 RS=470 RPD=10k RBM=1k RBE=1e12 RCOIL=70 LCOIL=0.1 V33=3.3 VG=3.3 RGPIO=40 RPU=1e12 RFON=1e12 RFOFF=1e12 TEMPC=27 TPULSE=0
.option temp={TEMPC}
.include models.lib
.option savecurrents
Vcc vcc 0 {VCC}
V33 v33 0 {V33}
Vg gsrc 0 PULSE({VG} {V33} 1m 1u 1u {TPULSE} 1)
Rg gsrc gpio {RGPIO}
Rpu v33 gpio {RPU}
Rs gpio line {RS}
Rpd line 0 {RPD}
Rfon v33 line {RFON}
Rfoff line 0 {RFOFF}
Rbm line b {RBM}
Rbe b 0 {RBE}
Q1 sw b 0 BC337-40
D1 sw vcc 1N4007
Rc vcc n1 {RCOIL}
Lc n1 sw {LCOIL}
Rl vcc nl 1k
Dl nl sw LEDRED
.control
set wr_vecnames
set wr_singlescale
op
let ib = @rbm[i]
let icoil = @rc[i]
let vcoil = v(vcc)-v(sw)
let igpio = -i(Vg)
let i33 = -i(V33)
print v(line) v(gpio) v(sw) ib icoil vcoil igpio i33

quit
.endc
.end
