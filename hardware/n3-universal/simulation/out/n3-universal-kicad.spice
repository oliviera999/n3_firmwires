.title KiCad schematic
.include "../../kicad/n3u_sim.lib"
R19 US3 US_POTA_DIV 2k
R23 +3V3_SW DHT_INT 10k
C4 +3V3_SW GND 100n
R26 +3V3_SW I2C_SCL 4.7k
R25 +3V3_SW I2C_SDA 4.7k
R27 ADC_E_IN ADC_E_DIV 10k
Q3 REL3_SW REL3_B GND BC337-40
DLED2 REL2_LED REL2_SW LEDRED
R62 +3V3 REL2_ON 1k
R11 +5V REL3_LED 1k
R3 K3 REL3_B 1k
R7 REL3_B GND 10k
C3 +3V3_SW GND 100n
R24 +3V3_SW ONEWIRE 4.7k
D3 REL3_SW +5V 1N4007
DLED3 REL3_LED REL3_SW LEDRED
RD5 VIN_5V +5V 1m
MQ12 VIN_RAW Q12_G +5V IRF4905
R57 Q12_G GND 100k
D12 GND +5V TVS68
C1 +5V GND 1000u
R13 +5V PWR_LED 1k
DLED5 PWR_LED GND LEDGREEN
C2 LDO_IN GND 470u
R21 SERVO2 SERVO_PETITS_SIG 220
R20 SERVO1 SERVO_GROS_SIG 220
R64 +3V3 REL4_ON 1k
R4 K4 REL4_B 1k
R8 REL4_B GND 10k
R12 +5V REL4_LED 1k
Q4 REL4_SW REL4_B GND BC337-40
D4 REL4_SW +5V 1N4007
DLED4 REL4_LED REL4_SW LEDRED
R28 K5 REL5_B 1k
R29 REL5_B GND 10k
R30 +5V REL5_LED 1k
D6 REL5_SW +5V 1N4007
Q5 REL5_SW REL5_B GND BC337-40
DLED6 REL5_LED REL5_SW LEDRED
R65 +3V3 REL5_ON 1k
R66 +3V3 REL6_ON 1k
Q6 REL6_SW REL6_B GND BC337-40
R33 +5V REL6_LED 1k
R47 +3V3_SW DHT_EXT_PU 10k
D7 REL6_SW +5V 1N4007
DLED7 REL6_LED REL6_SW LEDRED
R31 K6 REL6_B 1k
R32 REL6_B GND 10k
DLED1 REL1_LED REL1_SW LEDRED
R5 REL1_B GND 10k
R9 +5V REL1_LED 1k
R61 +3V3 REL1_ON 1k
R14 US_AQUA_ECHO US1 1k
D1 REL1_SW +5V 1N4007
R48 GATE_B GND 10k
R1 K1 REL1_B 1k
Q1 REL1_SW REL1_B GND BC337-40
R34 GATE GATE_B 1k
R35 +5V GATE_G 100k
Q8 GATE_G GATE_B GND BC337-40
MQ7 LDO_IN GATE_G +5V IRF4905
Q2 REL2_SW REL2_B GND BC337-40
D2 REL2_SW +5V 1N4007
R6 REL2_B GND 10k
R10 +5V REL2_LED 1k
R17 US1 US_AQUA_DIV 2k
R15 US_TANK_ECHO US2 1k
R18 US2 US_TANK_DIV 2k
R16 US_POTA_ECHO US3 1k
R2 K2 REL2_B 1k
R38 VBAT_SENSE VBAT_DIV 100k
R43 ADC_A_IN ADC_A_DIV 10k
R44 ADC_B_IN ADC_B_DIV 10k
R45 ADC_C_IN ADC_C_DIV 10k
R46 ADC_D_IN ADC_D_DIV 10k
C6 ADC_A GND 100n
C7 ADC_B GND 100n
R51 ADC_B_IN ADC_B 1k
R50 ADC_A_IN ADC_A 1k
C10 ADC_E GND 100n
C8 ADC_C GND 100n
C9 ADC_D GND 100n
R54 ADC_E_IN ADC_E 1k
R52 ADC_C_IN ADC_C 1k
R53 ADC_D_IN ADC_D 1k
D9 QP_G VBAT12_PROT Z15
MQ11 VBAT12_IN QP_G VBAT12_PROT IRF4905
C5 VBAT12_PROT GND 470u
D8 GND VBAT12_PROT TVS18
R40 QP_G GND 100k
XU1 LDO_IN +3V3_SW GND LD1117V33
C11 LDO_IN GND 10u
C12 +3V3_SW GND 100u
D11 ADC_VBAT +3V3 BAT85
C13 ADC_VBAT GND 100n
R58 VBAT_100K GND 100k
R49 VBAT_DIV ADC_VBAT 1k
R39 VBAT_22K GND 18k
.end
