.title KiCad schematic
.include "../../kicad/n3u_sim.lib"
R26 +3V3_SW I2C_SCL 4.7k
C4 +3V3_SW GND 100n
C3 +3V3_SW GND 100n
R8 CMD4 GND 10k
R24 +3V3_SW ONEWIRE 4.7k
R25 +3V3_SW I2C_SDA 4.7k
R28 K5 CMD5 470
R29 CMD5 GND 10k
R27 ADC_E_IN ADC_E_DIV 10k
R31 K6 CMD6 470
R32 CMD6 GND 10k
R57 Q12_G GND 100k
MQ12 VIN_RAW Q12_G +5V IRF4905
D5 +5V VIN_5V 1N5822
C14 VIN_5V GND 220u
C1 +5V GND 1000u
R13 +5V PWR_LED 1k
D12 GND +5V TVS68
R21 SERVO2 SERVO_PETITS_SIG 220
C2 LDO_IN GND 470u
R20 SERVO1 SERVO_GROS_SIG 220
DLED5 PWR_LED GND LEDGREEN
R5 CMD1 GND 10k
R14 US_AQUA_ECHO US1 1k
R18 US2 US_TANK_DIV 2k
R16 US_POTA_ECHO US3 1k
R19 US3 US_POTA_DIV 2k
R23 +3V3_SW DHT_INT 10k
R4 K4 CMD4 470
R7 CMD3 GND 10k
R17 US1 US_AQUA_DIV 2k
R15 US_TANK_ECHO US2 1k
R2 K2 CMD2 470
R6 CMD2 GND 10k
R3 K3 CMD3 470
MQ11 VBAT12_IN QP_G VBAT12_PROT IRF4905
C5 VBAT12_PROT GND 470u
R40 QP_G GND 100k
D8 GND VBAT12_PROT TVS18
R47 +3V3_SW DHT_EXT_PU 10k
R1 K1 CMD1 470
R35 +5V GATE_G 100k
R48 GATE_B GND 10k
MQ7 LDO_IN GATE_G +5V IRF4905
R38 VBAT_SENSE VBAT_DIV 100k
Q8 GATE_G GATE_B GND BC337-40
R34 GATE GATE_B 1k
C11 LDO_IN GND 10u
C12 +3V3_SW GND 100u
XU1 LDO_IN +3V3_SW GND LD1117V33
R39 VBAT_22K GND 18k
R58 VBAT_100K GND 100k
C13 ADC_VBAT GND 100n
D11 ADC_VBAT +3V3 BAT85
D9 QP_G VBAT12_PROT Z15
R49 VBAT_DIV ADC_VBAT 1k
R43 ADC_A_IN ADC_A_DIV 10k
R44 ADC_B_IN ADC_B_DIV 10k
R45 ADC_C_IN ADC_C_DIV 10k
R46 ADC_D_IN ADC_D_DIV 10k
C6 ADC_A GND 100n
C7 ADC_B GND 100n
C10 ADC_E GND 100n
C8 ADC_C GND 100n
C9 ADC_D GND 100n
R52 ADC_C_IN ADC_C 1k
R50 ADC_A_IN ADC_A 1k
R51 ADC_B_IN ADC_B 1k
R53 ADC_D_IN ADC_D 1k
R54 ADC_E_IN ADC_E 1k
.end
